* RC low-pass transient example for LTspice batch test
V1 in 0 PULSE(0 5 0 1u 1u 5m 10m)
R1 in out 1k
C1 out 0 1u
.tran 0 50m 0 10u
.meas tran vmax_out MAX V(out)
.meas tran vfinal FIND V(out) AT=50m
.end
