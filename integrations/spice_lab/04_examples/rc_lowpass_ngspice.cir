* RC low-pass example
V1 in 0 PULSE(0 5 0 1u 1u 5m 10m)
R1 in out 1k
C1 out 0 1u
.tran 10u 50m
.meas tran vmax_out MAX v(out)
.meas tran vfinal FIND v(out) AT=50m
.control
run
wrdata rc_lowpass.csv time v(in) v(out)
.endc
.end
